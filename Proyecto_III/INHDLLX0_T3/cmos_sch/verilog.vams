// Verilog-AMS netlist generated by the AMS netlister, version  IC6.1.7-64b.500.23 .
// Cadence Design Systems, Inc.

`include "disciplines.vams"

(* cds_ams_schematic *)
module INHDLLX0 ( A,.gnd(\gnd! ),Q,.vdd(\vdd! ) );

input   A;
inout  (*
integer inh_conn_prop_name = "ground_gnd";

integer inh_conn_def_value = "cds_globals.\\gnd! ";
 *)
 \gnd! ;

output   Q;
inout  (*
integer inh_conn_prop_name = "power_vdd";

integer inh_conn_def_value = "cds_globals.\\vdd! ";
 *)
 \vdd! ;

invr #(.lc(2.7e-07), .GT_PDW(420.00n), .sx(4.8e-07), .GT_PDL(210.00n),
 .GT_PUW(720.00n), .GT_PUL(210.000n)) (*
integer library_binding
 = "GATES_HD";
 *)
invr_1 ( .in( A ), .out( Q ) );

endmodule

//Verilog-AMS HDL for "D_CELLS_HDLL", "INHDLLX0" "verilogams"

`include "constants.vams"
`include "disciplines.vams"

// Created by ihdl
`timescale 1ns/10ps

`celldefine

module INHDLLX0 (A, Q);
//*****************************************************************
//   technology       : 180 nm HV SOI CMOS
//   module name      : INHDLLX0
//   version          : 1.3.0, Tue Apr 28 06:15:00 2020
//   cell_description : Inverter
//   last modified by : XLIB_PROC generated
//****************************************************************************
input (* integer supplySensitivity="\\vdd! "; integer groundSensitivity="\\gnd! "; *) A;
output (* integer supplySensitivity="\\vdd! "; integer groundSensitivity="\\gnd! "; *) Q;
electrical (* integer inh_conn_prop_name="ground_gnd"; integer inh_conn_def_value="cds_globals.\\gnd! "; *) \gnd! ;
electrical (* integer inh_conn_prop_name="power_vdd"; integer inh_conn_def_value="cds_globals.\\vdd! "; *) \vdd! ;

// logic section:

// Function Q: !(A)
	not	i0 (Q, A);

// timing section:
   specify
      (A -=> Q) = (0.02, 0.02);
   endspecify

endmodule

`endcelldefine
